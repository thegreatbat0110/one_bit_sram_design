** sch_path: /home/kaavya/chip/SRAM_SKY130/xschem/sense_amplifier.sch
**.subckt sense_amplifier dout VDD blb bl read_en
*.ipin VDD
*.iopin bl
*.iopin blb
*.ipin read_en
*.opin dout
XM1 dout_g dout_b VDD VDD sky130_fd_pr__pfet_01v8 L=0.15 W=1.26 nf=1 ad=0.3654 as=0.3654 pd=3.1 ps=3.1 nrd=0.23015873015873
+ nrs=0.23015873015873 sa=0 sb=0 sd=0 mult=1
XM2 dout_b dout_g VDD VDD sky130_fd_pr__pfet_01v8 L=0.15 W=1.26 nf=1 ad=0.3654 as=0.3654 pd=3.1 ps=3.1 nrd=0.23015873015873
+ nrs=0.23015873015873 sa=0 sb=0 sd=0 mult=1
XM3 dout_g dout_b net1 0 sky130_fd_pr__nfet_01v8 L=0.15 W=0.84 nf=1 ad=0.2436 as=0.2436 pd=2.26 ps=2.26 nrd=0.345238095238095
+ nrs=0.345238095238095 sa=0 sb=0 sd=0 mult=1
XM4 dout_b dout_g net1 0 sky130_fd_pr__nfet_01v8 L=0.15 W=0.84 nf=1 ad=0.2436 as=0.2436 pd=2.26 ps=2.26 nrd=0.345238095238095
+ nrs=0.345238095238095 sa=0 sb=0 sd=0 mult=1
XM5 dout_b bl net1 0 sky130_fd_pr__nfet_01v8 L=0.15 W=0.84 nf=1 ad=0.2436 as=0.2436 pd=2.26 ps=2.26 nrd=0.345238095238095
+ nrs=0.345238095238095 sa=0 sb=0 sd=0 mult=1
XM7 dout_g blb net1 0 sky130_fd_pr__nfet_01v8 L=0.15 W=0.84 nf=1 ad=0.2436 as=0.2436 pd=2.26 ps=2.26 nrd=0.345238095238095
+ nrs=0.345238095238095 sa=0 sb=0 sd=0 mult=1
XM6 net1 read_en 0 0 sky130_fd_pr__nfet_01v8 L=0.15 W=0.42 nf=1 ad=0.1218 as=0.1218 pd=1.42 ps=1.42 nrd=0.69047619047619
+ nrs=0.69047619047619 sa=0 sb=0 sd=0 mult=1
C1 dout_g 0 10f
C2 dout_b 0 10f
XM10 dout_g read_en VDD VDD sky130_fd_pr__pfet_01v8 L=0.15 W=1.26 nf=1 ad=0.3654 as=0.3654 pd=3.1 ps=3.1 nrd=0.23015873015873
+ nrs=0.23015873015873 sa=0 sb=0 sd=0 mult=1
XM11 dout_b read_en VDD VDD sky130_fd_pr__pfet_01v8 L=0.15 W=1.26 nf=1 ad=0.3654 as=0.3654 pd=3.1 ps=3.1 nrd=0.23015873015873
+ nrs=0.23015873015873 sa=0 sb=0 sd=0 mult=1
XM8 dout dout_b VDD VDD sky130_fd_pr__pfet_01v8 L=0.15 W=1.26 nf=1 ad=0.3654 as=0.3654 pd=3.1 ps=3.1 nrd=0.23015873015873
+ nrs=0.23015873015873 sa=0 sb=0 sd=0 mult=1
XM9 dout dout_b 0 0 sky130_fd_pr__nfet_01v8 L=0.15 W=0.84 nf=1 ad=0.2436 as=0.2436 pd=2.26 ps=2.26 nrd=0.345238095238095
+ nrs=0.345238095238095 sa=0 sb=0 sd=0 mult=1
**.ends
.GLOBAL dout_b
.GLOBAL dout_g
.GLOBAL read_en
.GLOBAL VDD
.end

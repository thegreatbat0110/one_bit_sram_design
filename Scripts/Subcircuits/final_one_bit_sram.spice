** sch_path: /home/kaavya/chip/SRAM_SKY130/xschem/final_one_bit_sram.sch
**.subckt final_one_bit_sram
x1 prec blb bl VDD precharge
x4 write_en blb bl VDD din write_driver
x3 wl VDD blb bl Q QB six_t
x2 dout VDD blb bl read_en sense_amplifier
**** begin user architecture code

**** begin user architecture code
**change tt at end of .lib line to ss and ff
.lib /home/kaavya/.ciel/ciel/sky130/versions/9233c19260cd813c3fa67dd4594fe4cc67016832/sky130A/libs.tech/ngspice/sky130.lib.spice tt
*------------------------------------------------------------------------------
* SUPPLY, INITIAL STATE, BITLINE LOADS
*------------------------------------------------------------------------------
V1 vdd gnd dc 1.8

.ic v(Q)=1.8 v(QB)=0

Cbl  bl  gnd 100f
Cblb blb gnd 100f

*------------------------------------------------------------------------------
* PRECHARGE (active LOW)
*------------------------------------------------------------------------------
Vprec prec gnd PWL
+0n      0
+5.00n   0
+5.06n   1.8

+20.00n  1.8
+20.06n  0
+25.00n  0
+25.06n  1.8

+40.00n  1.8
+40.06n  0
+45.00n  0
+45.06n  1.8

+60.00n  1.8
+60.06n  0
+65.00n  0
+65.06n  1.8

+80.00n  1.8
+80.06n  0
+85.00n  0
+85.06n  1.8

+95.00n  1.8
+95.06n  0
+99.00n  0
+99.06n  1.8
+100n    1.8

*------------------------------------------------------------------------------
* WORDLINE
*------------------------------------------------------------------------------
Vwl wl gnd PWL
+0n        0

* Write 0
+10.12n    0
+10.18n    1.8
+16.12n    1.8
+16.18n    0

* Read 0
+50.12n    0
+50.18n    1.8
+51.00n    1.8
+51.06n    0

* Write 1
+70.12n    0
+70.18n    1.8
+76.12n    1.8
+76.18n    0

* Read 1
+90.12n    0
+90.18n    1.8
+91.00n    1.8
+91.06n    0

+100n      0

*------------------------------------------------------------------------------
* WRITE ENABLE
*------------------------------------------------------------------------------
Vwrite_en write_en gnd PWL
+0n        0

* Write 0
+10.26n    0
+10.32n    1.8
+13.26n    1.8
+13.32n    0

* Write 1
+70.26n    0
+70.32n    1.8
+73.26n    1.8
+73.32n    0

+100n      0

*------------------------------------------------------------------------------
* READ ENABLE
*------------------------------------------------------------------------------
Vread_en read_en gnd PWL
+0n         0

* Read 0
+50.26n     0
+50.32n     1.8
+51.82n     1.8
+51.88n     0

* Read 1
+90.26n     0
+90.32n     1.8
+91.82n     1.8
+91.88n     0

+100n       0

*------------------------------------------------------------------------------
* DATA IN
*------------------------------------------------------------------------------
Vdin din gnd PWL
+0n       0
+60.00n   0
+60.06n   1.8
+100n     1.8

*------------------------------------------------------------------------------
* SIMULATION
*------------------------------------------------------------------------------
.tran 0.1p 100n
.temp 27

*==============================================================================
* 1. WRITE DELAY
*==============================================================================
.meas tran t_write0_50
+ TRIG v(wl) VAL=0.9 RISE=1 TD=9n
+ TARG v(Q)  VAL=0.9 FALL=1 TD=9n

.meas tran t_write0_10
+ TRIG v(wl) VAL=0.9 RISE=1 TD=9n
+ TARG v(Q)  VAL=0.18 FALL=1 TD=9n

.meas tran t_write1_50
+ TRIG v(wl) VAL=0.9 RISE=1 TD=69n
+ TARG v(Q)  VAL=0.9 RISE=1 TD=69n

.meas tran t_write1_90
+ TRIG v(wl) VAL=0.9 RISE=1 TD=69n
+ TARG v(Q)  VAL=1.62 RISE=1 TD=69n

*==============================================================================
* 2. FUNCTIONAL CHECKS (read checks just before read_en falls)
*==============================================================================
.meas tran q_after_write0  FIND v(Q)  AT=18n
.meas tran qb_after_write0 FIND v(QB) AT=18n

.meas tran dout_read0 FIND v(dout)   AT=51.6n
.meas tran dg_read0   FIND v(dout_g) AT=51.6n
.meas tran db_read0   FIND v(dout_b) AT=51.6n

.meas tran q_after_write1  FIND v(Q)  AT=78n
.meas tran qb_after_write1 FIND v(QB) AT=78n

.meas tran dout_read1 FIND v(dout)   AT=91.6n
.meas tran dg_read1   FIND v(dout_g) AT=91.6n
.meas tran db_read1   FIND v(dout_b) AT=91.6n

*==============================================================================
* 3. READ TIMING AND OUTPUT CHECKS
*==============================================================================
* read_en -> DOUT (READ 1)
.meas tran t_read1_50
+ TRIG v(read_en) VAL=0.9 RISE=1 TD=89n
+ TARG v(dout)    VAL=0.9 RISE=1 TD=89n

.meas tran t_read1_90
+ TRIG v(read_en) VAL=0.9 RISE=1 TD=89n
+ TARG v(dout)    VAL=1.62 RISE=1 TD=89n

* Latch resolution (separation of latch nodes reaches 0.8 V)
.meas tran t_res1
+ TRIG v(read_en) VAL=0.9 RISE=1 TD=89n
+ TARG par('v(dout_g)-v(dout_b)') VAL=0.8 RISE=1 TD=89n

.meas tran t_res0
+ TRIG v(read_en) VAL=0.9 RISE=1 TD=49n
+ TARG par('v(dout_b)-v(dout_g)') VAL=0.8 RISE=1 TD=49n

* Glitch robustness: DOUT must stay low in READ 0 and high in READ 1
.meas tran dout_max_read0 MAX v(dout) FROM=50.3n TO=51.8n
.meas tran dout_min_read1 MIN v(dout) FROM=91.0n TO=91.8n

*==============================================================================
* 4. READ DISTURB
*==============================================================================
.meas tran q_before_read0 AVG v(Q)
+ FROM=49n TO=50n
.meas tran q_read0_max MAX v(Q)
+ FROM=50.18n TO=51.06n
.meas tran read0_disturb
+ PARAM='q_read0_max-q_before_read0'
* Lowest point of the READ 0 winner node (must stay above the inverter trip point)
.meas tran db_min_read0 MIN v(dout_b) FROM=50.3n TO=51.8n
.meas tran qb_before_read1 AVG v(QB)
+ FROM=89n TO=90n
.meas tran qb_read1_max MAX v(QB)
+ FROM=90.18n TO=91.06n
.meas tran read1_disturb
+ PARAM='qb_read1_max-qb_before_read1'

*==============================================================================
* 5. BITLINE DIFFERENTIAL (sae = at sense enable, wlf = at WL fall)
*==============================================================================
.meas tran bl_sae0  FIND v(bl)  AT=50.32n
.meas tran blb_sae0 FIND v(blb) AT=50.32n
.meas tran dbl_sae0 PARAM='abs(bl_sae0-blb_sae0)'

.meas tran bl_wlf0  FIND v(bl)  AT=51.06n
.meas tran blb_wlf0 FIND v(blb) AT=51.06n
.meas tran dbl_wlf0 PARAM='abs(bl_wlf0-blb_wlf0)'

.meas tran bl_sae1  FIND v(bl)  AT=90.32n
.meas tran blb_sae1 FIND v(blb) AT=90.32n
.meas tran dbl_sae1 PARAM='abs(bl_sae1-blb_sae1)'

.meas tran bl_wlf1  FIND v(bl)  AT=91.06n
.meas tran blb_wlf1 FIND v(blb) AT=91.06n
.meas tran dbl_wlf1 PARAM='abs(bl_wlf1-blb_wlf1)'

*==============================================================================
* 6. ENERGY PER CYCLE (INCLUDING FOLLOWING PRECHARGE)
* i(V1) is negative when the supply delivers current. If energies come out
* negative, remove the minus sign.
*==============================================================================
.meas tran q_w0 INTEG i(V1) FROM=10n TO=30n
.meas tran e_write0 PARAM='-1.8*q_w0'

.meas tran q_r0 INTEG i(V1) FROM=50n TO=68n
.meas tran e_read0 PARAM='-1.8*q_r0'

.meas tran q_w1 INTEG i(V1) FROM=70n TO=88n
.meas tran e_write1 PARAM='-1.8*q_w1'

.meas tran q_r1 INTEG i(V1) FROM=90n TO=100n
.meas tran e_read1 PARAM='-1.8*q_r1'

*==============================================================================
* 7. HOLD CHECK
*==============================================================================
.meas tran q_hold0_avg  AVG v(Q)  FROM=30n TO=39n
.meas tran qb_hold0_avg AVG v(QB) FROM=30n TO=39n
.meas tran q_hold1_avg  AVG v(Q)  FROM=87n TO=89n
.meas tran qb_hold1_avg AVG v(QB) FROM=87n TO=89n

*==============================================================================
* SAVE / CONTROL
*==============================================================================
.save all

.control
run
*remove run - batch mode will not work - run only for plotting the waveforms
plot bl+2 blb
plot prec+8 wl+6
plot write_en+4 read_en+2
plot Q+2 QB
plot dout
*plot dout_g+2 dout_b
.endc
**** end user architecture code

**** end user architecture code
**.ends

* expanding   symbol:  precharge.sym # of pins=4
** sym_path: /home/kaavya/chip/SRAM_SKY130/xschem/precharge.sym
** sch_path: /home/kaavya/chip/SRAM_SKY130/xschem/precharge.sch
.subckt precharge precharge blb bl VDD
*.ipin precharge
*.iopin bl
*.iopin blb
*.ipin VDD
XM1 blb precharge VDD VDD sky130_fd_pr__pfet_01v8 L=0.15 W=2 nf=1 ad=0.58 as=0.58 pd=4.58 ps=4.58 nrd=0.145 nrs=0.145 sa=0 sb=0
+ sd=0 mult=1
XM2 bl precharge VDD VDD sky130_fd_pr__pfet_01v8 L=0.15 W=2 nf=1 ad=0.58 as=0.58 pd=4.58 ps=4.58 nrd=0.145 nrs=0.145 sa=0 sb=0
+ sd=0 mult=1
XM3 blb precharge bl VDD sky130_fd_pr__pfet_01v8 L=0.15 W=2 nf=1 ad=0.58 as=0.58 pd=4.58 ps=4.58 nrd=0.145 nrs=0.145 sa=0 sb=0
+ sd=0 mult=1
.ends

* expanding   symbol:  write_driver.sym # of pins=5
** sym_path: /home/kaavya/chip/SRAM_SKY130/xschem/write_driver.sym
** sch_path: /home/kaavya/chip/SRAM_SKY130/xschem/write_driver.sch
.subckt write_driver write_en blb bl VDD din
*.ipin VDD
*.ipin write_en
*.ipin din
*.iopin bl
*.iopin blb
XM3 net1 din 0 0 sky130_fd_pr__nfet_01v8 L=0.15 W=1 nf=1 ad=0.29 as=0.29 pd=2.58 ps=2.58 nrd=0.29 nrs=0.29 sa=0 sb=0 sd=0 mult=1
XM4 net1 din VDD VDD sky130_fd_pr__pfet_01v8 L=0.15 W=1 nf=1 ad=0.29 as=0.29 pd=2.58 ps=2.58 nrd=0.29 nrs=0.29 sa=0 sb=0 sd=0
+ mult=1
XM5 net2 net1 0 0 sky130_fd_pr__nfet_01v8 L=0.15 W=1 nf=1 ad=0.29 as=0.29 pd=2.58 ps=2.58 nrd=0.29 nrs=0.29 sa=0 sb=0 sd=0 mult=1
XM6 net2 net1 VDD VDD sky130_fd_pr__pfet_01v8 L=0.15 W=1 nf=1 ad=0.29 as=0.29 pd=2.58 ps=2.58 nrd=0.29 nrs=0.29 sa=0 sb=0 sd=0
+ mult=1
XM8 net3 write_en 0 0 sky130_fd_pr__nfet_01v8 L=0.15 W=4 nf=1 ad=1.16 as=1.16 pd=8.58 ps=8.58 nrd=0.0725 nrs=0.0725 sa=0 sb=0 sd=0
+ mult=1
XM9 net4 write_en 0 0 sky130_fd_pr__nfet_01v8 L=0.15 W=4 nf=1 ad=1.16 as=1.16 pd=8.58 ps=8.58 nrd=0.0725 nrs=0.0725 sa=0 sb=0 sd=0
+ mult=1
XM7 bl net1 net3 0 sky130_fd_pr__nfet_01v8 L=0.15 W=4 nf=1 ad=1.16 as=1.16 pd=8.58 ps=8.58 nrd=0.0725 nrs=0.0725 sa=0 sb=0 sd=0
+ mult=1
XM10 blb net2 net4 0 sky130_fd_pr__nfet_01v8 L=0.15 W=4 nf=1 ad=1.16 as=1.16 pd=8.58 ps=8.58 nrd=0.0725 nrs=0.0725 sa=0 sb=0 sd=0
+ mult=1
.ends

* expanding   symbol:  six_t.sym # of pins=6
** sym_path: /home/kaavya/chip/SRAM_SKY130/xschem/six_t.sym
** sch_path: /home/kaavya/chip/SRAM_SKY130/xschem/six_t.sch
.subckt six_t wl VDD blb bl Q QB
*.iopin bl
*.opin Q
*.opin QB
*.ipin wl
*.ipin VDD
*.iopin blb
XM3 QB Q 0 0 sky130_fd_pr__nfet_01v8 L=0.15 W=1.26 nf=1 ad='int((nf+1)/2) * W/nf * 0.29' as='int((nf+2)/2) * W/nf * 0.29' pd='2*int((nf+1)/2) * (W/nf + 0.29)'
+ ps='2*int((nf+2)/2) * (W/nf + 0.29)' nrd='0.29 / W' nrs='0.29 / W' sa=0 sb=0 sd=0 mult=1
XM4 QB wl blb 0 sky130_fd_pr__nfet_01v8 L=0.15 W=0.55 nf=1 ad='int((nf+1)/2) * W/nf * 0.29' as='int((nf+2)/2) * W/nf * 0.29' pd='2*int((nf+1)/2) * (W/nf + 0.29)'
+ ps='2*int((nf+2)/2) * (W/nf + 0.29)' nrd='0.29 / W' nrs='0.29 / W' sa=0 sb=0 sd=0 mult=1
XM5 Q wl bl 0 sky130_fd_pr__nfet_01v8 L=0.15 W=0.55 nf=1 ad='int((nf+1)/2) * W/nf * 0.29' as='int((nf+2)/2) * W/nf * 0.29' pd='2*int((nf+1)/2) * (W/nf + 0.29)'
+ ps='2*int((nf+2)/2) * (W/nf + 0.29)' nrd='0.29 / W' nrs='0.29 / W' sa=0 sb=0 sd=0 mult=1
XM6 Q QB VDD VDD sky130_fd_pr__pfet_01v8 L=0.15 W=0.55 nf=1 ad='int((nf+1)/2) * W/nf * 0.29' as='int((nf+2)/2) * W/nf * 0.29' pd='2*int((nf+1)/2) * (W/nf + 0.29)'
+ ps='2*int((nf+2)/2) * (W/nf + 0.29)' nrd='0.29 / W' nrs='0.29 / W' sa=0 sb=0 sd=0 mult=1
XM7 QB Q VDD VDD sky130_fd_pr__pfet_01v8 L=0.15 W=0.55 nf=1 ad='int((nf+1)/2) * W/nf * 0.29' as='int((nf+2)/2) * W/nf * 0.29' pd='2*int((nf+1)/2) * (W/nf + 0.29)'
+ ps='2*int((nf+2)/2) * (W/nf + 0.29)' nrd='0.29 / W' nrs='0.29 / W' sa=0 sb=0 sd=0 mult=1
XM1 Q QB 0 0 sky130_fd_pr__nfet_01v8 L=0.15 W=1.26 nf=1 ad='int((nf+1)/2) * W/nf * 0.29' as='int((nf+2)/2) * W/nf * 0.29' pd='2*int((nf+1)/2) * (W/nf + 0.29)'
+ ps='2*int((nf+2)/2) * (W/nf + 0.29)' nrd='0.29 / W' nrs='0.29 / W' sa=0 sb=0 sd=0 mult=1
.ends

* expanding   symbol:  sense_amplifier.sym # of pins=5
** sym_path: /home/kaavya/chip/SRAM_SKY130/xschem/sense_amplifier.sym
** sch_path: /home/kaavya/chip/SRAM_SKY130/xschem/sense_amplifier.sch
.subckt sense_amplifier dout VDD blb bl read_en
*.ipin VDD
*.iopin bl
*.iopin blb
*.ipin read_en
*.opin dout
XM1 dout_g dout_b VDD VDD sky130_fd_pr__pfet_01v8 L=0.15 W=1.26 nf=1 ad=0.3654 as=0.3654 pd=3.1 ps=3.1 nrd=0.23015873015873
+ nrs=0.23015873015873 sa=0 sb=0 sd=0 mult=1
XM2 dout_b dout_g VDD VDD sky130_fd_pr__pfet_01v8 L=0.15 W=1.26 nf=1 ad=0.3654 as=0.3654 pd=3.1 ps=3.1 nrd=0.23015873015873
+ nrs=0.23015873015873 sa=0 sb=0 sd=0 mult=1
XM3 dout_g dout_b net1 0 sky130_fd_pr__nfet_01v8 L=0.15 W=0.84 nf=1 ad=0.2436 as=0.2436 pd=2.26 ps=2.26 nrd=0.345238095238095
+ nrs=0.345238095238095 sa=0 sb=0 sd=0 mult=1
XM4 dout_b dout_g net1 0 sky130_fd_pr__nfet_01v8 L=0.15 W=0.84 nf=1 ad=0.2436 as=0.2436 pd=2.26 ps=2.26 nrd=0.345238095238095
+ nrs=0.345238095238095 sa=0 sb=0 sd=0 mult=1
XM5 dout_b bl net1 0 sky130_fd_pr__nfet_01v8 L=0.15 W=0.84 nf=1 ad=0.2436 as=0.2436 pd=2.26 ps=2.26 nrd=0.345238095238095
+ nrs=0.345238095238095 sa=0 sb=0 sd=0 mult=1
XM7 dout_g blb net1 0 sky130_fd_pr__nfet_01v8 L=0.15 W=0.84 nf=1 ad=0.2436 as=0.2436 pd=2.26 ps=2.26 nrd=0.345238095238095
+ nrs=0.345238095238095 sa=0 sb=0 sd=0 mult=1
XM6 net1 read_en 0 0 sky130_fd_pr__nfet_01v8 L=0.15 W=0.42 nf=1 ad=0.1218 as=0.1218 pd=1.42 ps=1.42 nrd=0.69047619047619
+ nrs=0.69047619047619 sa=0 sb=0 sd=0 mult=1
C1 dout_g 0 10f
C2 dout_b 0 10f
XM10 dout_g read_en VDD VDD sky130_fd_pr__pfet_01v8 L=0.15 W=1.26 nf=1 ad=0.3654 as=0.3654 pd=3.1 ps=3.1 nrd=0.23015873015873
+ nrs=0.23015873015873 sa=0 sb=0 sd=0 mult=1
XM11 dout_b read_en VDD VDD sky130_fd_pr__pfet_01v8 L=0.15 W=1.26 nf=1 ad=0.3654 as=0.3654 pd=3.1 ps=3.1 nrd=0.23015873015873
+ nrs=0.23015873015873 sa=0 sb=0 sd=0 mult=1
XM8 dout dout_b VDD VDD sky130_fd_pr__pfet_01v8 L=0.15 W=1.26 nf=1 ad=0.3654 as=0.3654 pd=3.1 ps=3.1 nrd=0.23015873015873
+ nrs=0.23015873015873 sa=0 sb=0 sd=0 mult=1
XM9 dout dout_b 0 0 sky130_fd_pr__nfet_01v8 L=0.15 W=0.84 nf=1 ad=0.2436 as=0.2436 pd=2.26 ps=2.26 nrd=0.345238095238095
+ nrs=0.345238095238095 sa=0 sb=0 sd=0 mult=1
.ends

.GLOBAL VDD
.GLOBAL wl
.GLOBAL Q
.GLOBAL QB
.GLOBAL prec
.GLOBAL read_en
.GLOBAL dout
.GLOBAL din
.GLOBAL write_en
.GLOBAL dout_b
.GLOBAL dout_g
.end
